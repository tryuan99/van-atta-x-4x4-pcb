# Ansys Electronics Desktop project, version 2025.2
materials:
  vacuum: permittivity=1
  Rogers RO4350 (tm): permittivity=3.66 dielectric_loss_tangent=0.004
  copper: permeability=0.999991 conductivity=58000000
  air: permittivity=1.0006 permeability=1.0000004
  pec: conductivity=1e+30
  Rogers RO4450T: permittivity=3.24 conductivity=1.12e-09 dielectric_loss_tangent=0.0044
  FR4_epoxy: permittivity=4.4 dielectric_loss_tangent=0.02
  Rogers RO4450F: permittivity=3.52 conductivity=1.12e-09 dielectric_loss_tangent=0.004 delta_H_freq=10000000000
  rhodium: conductivity=22200000
  Rogers RO4003 (tm): permittivity=3.55 dielectric_loss_tangent=0.0027
  Teflon (tm): permittivity=2.1 dielectric_loss_tangent=0.001
  gold: permeability=0.99996 conductivity=41000000
  solder: conductivity=7000000
  beryllium copper: conductivity=12800000
  steel_stainless: conductivity=1100000

design van_atta_array_4L (HFSS, HFSS Modal Network, model units mm)
options: Allow_Material_Override Calculate_Lossy_Dielectrics
variables:
  f = 9GHz
  lambda = c0/f
  l_dielectric = 50mm
  h_prepreg = 18mil
  h_dielectric_antenna = 60mil
  h_dielectric_microstrip = 10mil
  r_via = 0.3mm
  r_via_clearance = 0.2mm
  y_feed = -0.70991249mm
  w_pcb = 4*lambda/2
  l_pcb = 4*lambda/2
  h_copper = 1copper_oz_per_ft2
geometry:
  coordinate_system RelativeCS1 = origin=(-3/4*lambda, -3/4*lambda, 0mm) x=(1mm, 0mm, 0mm) y=(0mm, 1mm, 0mm)
  coordinate_system RelativeCS2 = origin=(lambda/2, 0mm, 0mm) x=(1mm, 0mm, 0mm) y=(0mm, 1mm, 0mm) in RelativeCS1
  coordinate_system RelativeCS3 = origin=(lambda/2, 0mm, 0mm) x=(1mm, 0mm, 0mm) y=(0mm, 1mm, 0mm) in RelativeCS2
  coordinate_system RelativeCS4 = origin=(lambda/2, 0mm, 0mm) x=(1mm, 0mm, 0mm) y=(0mm, 1mm, 0mm) in RelativeCS3
  coordinate_system RelativeCS5 = origin=(-3/4*lambda, -1/4*lambda, 0mm) x=(1mm, 0mm, 0mm) y=(0mm, 1mm, 0mm)
  coordinate_system RelativeCS6 = origin=(lambda/2, 0mm, 0mm) x=(1mm, 0mm, 0mm) y=(0mm, 1mm, 0mm) in RelativeCS5
  coordinate_system RelativeCS7 = origin=(lambda/2, 0mm, 0mm) x=(1mm, 0mm, 0mm) y=(0mm, 1mm, 0mm) in RelativeCS6
  coordinate_system RelativeCS8 = origin=(lambda/2, 0mm, 0mm) x=(1mm, 0mm, 0mm) y=(0mm, 1mm, 0mm) in RelativeCS7
  RadiatingSurface [air] = region(absolute_offset=50mm on all sides)
  Prepreg [Rogers RO4450F] = box(corner=(-w_pcb/2, -l_pcb/2, 0mm), size=(w_pcb, l_pcb, h_prepreg))
  DielectricMicrostrip [Rogers RO4350 (tm)] = box(corner=(-w_pcb/2, -l_pcb/2, -h_copper), size=(w_pcb, l_pcb, -h_dielectric_microstrip))
  DielectricAntenna [Rogers RO4350 (tm)] = box(corner=(-w_pcb/2, -l_pcb/2, h_prepreg), size=(w_pcb, l_pcb, h_dielectric_antenna))
  Ground [copper] = box(corner=(-w_pcb/2, -l_pcb/2, 0mm), size=(w_pcb, l_pcb, -h_copper))
  Cylinder1 = cylinder(axis=Z, base_centre=(0mm, y_feed, 0), radius=r_via+r_via_clearance, height=-h_copper) in RelativeCS1
  Cylinder2 = cylinder(axis=Z, base_centre=(0mm, y_feed, 0), radius=r_via+r_via_clearance, height=-h_copper) in RelativeCS2
  Cylinder3 = cylinder(axis=Z, base_centre=(0mm, y_feed, 0), radius=r_via+r_via_clearance, height=-h_copper) in RelativeCS3
  Cylinder4 = cylinder(axis=Z, base_centre=(0mm, y_feed, 0), radius=r_via+r_via_clearance, height=-h_copper) in RelativeCS4
  Cylinder5 = cylinder(axis=Z, base_centre=(0mm, y_feed, 0), radius=r_via+r_via_clearance, height=-h_copper) in RelativeCS5
  Cylinder6 = cylinder(axis=Z, base_centre=(0mm, y_feed, 0), radius=r_via+r_via_clearance, height=-h_copper) in RelativeCS6
  Cylinder7 = cylinder(axis=Z, base_centre=(0mm, y_feed, 0), radius=r_via+r_via_clearance, height=-h_copper) in RelativeCS7
  Cylinder8 = cylinder(axis=Z, base_centre=(0mm, y_feed, 0), radius=r_via+r_via_clearance, height=-h_copper) in RelativeCS8
  Ground.subtract(Cylinder1..Cylinder8)
  coordinate_system RelativeCS9 = origin=(-3/4*lambda, 1/4*lambda, 0) x=(1mm, 0mm, 0mm) y=(0mm, 1mm, 0mm)
  coordinate_system RelativeCS10 = origin=(lambda/2, 0mm, 0mm) x=(1mm, 0mm, 0mm) y=(0mm, 1mm, 0mm) in RelativeCS9
  coordinate_system RelativeCS11 = origin=(lambda/2, 0mm, 0mm) x=(1mm, 0mm, 0mm) y=(0mm, 1mm, 0mm) in RelativeCS10
  coordinate_system RelativeCS12 = origin=(lambda/2, 0mm, 0mm) x=(1mm, 0mm, 0mm) y=(0mm, 1mm, 0mm) in RelativeCS11
  coordinate_system RelativeCS13 = origin=(-3/4*lambda, 3/4*lambda, 0mm) x=(1mm, 0mm, 0mm) y=(0mm, 1mm, 0mm)
  coordinate_system RelativeCS14 = origin=(lambda/2, 0mm, 0mm) x=(1mm, 0mm, 0mm) y=(0mm, 1mm, 0mm) in RelativeCS13
  coordinate_system RelativeCS15 = origin=(lambda/2, 0mm, 0mm) x=(1mm, 0mm, 0mm) y=(0mm, 1mm, 0mm) in RelativeCS14
  coordinate_system RelativeCS16 = origin=(lambda/2, 0mm, 0mm) x=(1mm, 0mm, 0mm) y=(0mm, 1mm, 0mm) in RelativeCS15
  u_slot_patch_antenna_ro4350b_4L1 = component(u_slot_patch_antenna_ro4350b_4L, 3D_Component_File_Path=C:/Users/tryua/Documents/Ansoft/u_slot_patch_antenna_ro4350b_4L_antenna.a3dcomp, h_copper=1copper_oz_per_ft2, h_dielectric_microstrip=10mil, w_patch=12.020559mm, l_patch=7.2503014mm, y_feed=-0.70991249mm, w_slot=5.0926129mm, l_slot=4.1381164mm, t_slot=0.58305664mm, y_slot=2.3182827mm, r_via=0.3mm, h_prepreg=18mil, h_dielectric_antenna=60mil)
  Patch, Via [copper] = part_of(u_slot_patch_antenna_ro4350b_4L1) in RelativeCS1
  u_slot_patch_antenna_ro4350b_4L1.placement() in RelativeCS1
  u_slot_patch_antenna_ro4350b_4L2 = component(u_slot_patch_antenna_ro4350b_4L, 3D_Component_File_Path=C:/Users/tryua/Documents/Ansoft/u_slot_patch_antenna_ro4350b_4L_antenna.a3dcomp, h_copper=1copper_oz_per_ft2, h_dielectric_microstrip=10mil, w_patch=12.020559mm, l_patch=7.2503014mm, y_feed=-0.70991249mm, w_slot=5.0926129mm, l_slot=4.1381164mm, t_slot=0.58305664mm, y_slot=2.3182827mm, r_via=0.3mm, h_prepreg=18mil, h_dielectric_antenna=60mil)
  u_slot_patch_antenna_ro4350b_4L2.placement() in RelativeCS2
  Patch2, Via2 [copper] = part_of(u_slot_patch_antenna_ro4350b_4L2) in RelativeCS2
  u_slot_patch_antenna_ro4350b_4L3 = component(u_slot_patch_antenna_ro4350b_4L, 3D_Component_File_Path=C:/Users/tryua/Documents/Ansoft/u_slot_patch_antenna_ro4350b_4L_antenna.a3dcomp, h_copper=1copper_oz_per_ft2, h_dielectric_microstrip=10mil, w_patch=12.020559mm, l_patch=7.2503014mm, y_feed=-0.70991249mm, w_slot=5.0926129mm, l_slot=4.1381164mm, t_slot=0.58305664mm, y_slot=2.3182827mm, r_via=0.3mm, h_prepreg=18mil, h_dielectric_antenna=60mil)
  u_slot_patch_antenna_ro4350b_4L3.placement() in RelativeCS3
  Patch3, Via3 [copper] = part_of(u_slot_patch_antenna_ro4350b_4L3) in RelativeCS3
  u_slot_patch_antenna_ro4350b_4L4 = component(u_slot_patch_antenna_ro4350b_4L, 3D_Component_File_Path=C:/Users/tryua/Documents/Ansoft/u_slot_patch_antenna_ro4350b_4L_antenna.a3dcomp, h_copper=1copper_oz_per_ft2, h_dielectric_microstrip=10mil, w_patch=12.020559mm, l_patch=7.2503014mm, y_feed=-0.70991249mm, w_slot=5.0926129mm, l_slot=4.1381164mm, t_slot=0.58305664mm, y_slot=2.3182827mm, r_via=0.3mm, h_prepreg=18mil, h_dielectric_antenna=60mil)
  u_slot_patch_antenna_ro4350b_4L4.placement() in RelativeCS4
  Patch4, Via4 [copper] = part_of(u_slot_patch_antenna_ro4350b_4L4) in RelativeCS4
  u_slot_patch_antenna_ro4350b_4L5 = component(u_slot_patch_antenna_ro4350b_4L, 3D_Component_File_Path=C:/Users/tryua/Documents/Ansoft/u_slot_patch_antenna_ro4350b_4L_antenna.a3dcomp, h_copper=1copper_oz_per_ft2, h_dielectric_microstrip=10mil, w_patch=12.020559mm, l_patch=7.2503014mm, y_feed=-0.70991249mm, w_slot=5.0926129mm, l_slot=4.1381164mm, t_slot=0.58305664mm, y_slot=2.3182827mm, r_via=0.3mm, h_prepreg=18mil, h_dielectric_antenna=60mil)
  u_slot_patch_antenna_ro4350b_4L5.placement() in RelativeCS5
  Patch5, Via5 [copper] = part_of(u_slot_patch_antenna_ro4350b_4L5) in RelativeCS5
  u_slot_patch_antenna_ro4350b_4L6 = component(u_slot_patch_antenna_ro4350b_4L, 3D_Component_File_Path=C:/Users/tryua/Documents/Ansoft/u_slot_patch_antenna_ro4350b_4L_antenna.a3dcomp, h_copper=1copper_oz_per_ft2, h_dielectric_microstrip=10mil, w_patch=12.020559mm, l_patch=7.2503014mm, y_feed=-0.70991249mm, w_slot=5.0926129mm, l_slot=4.1381164mm, t_slot=0.58305664mm, y_slot=2.3182827mm, r_via=0.3mm, h_prepreg=18mil, h_dielectric_antenna=60mil)
  u_slot_patch_antenna_ro4350b_4L6.placement() in RelativeCS6
  Patch6, Via6 [copper] = part_of(u_slot_patch_antenna_ro4350b_4L6) in RelativeCS6
  u_slot_patch_antenna_ro4350b_4L7 = component(u_slot_patch_antenna_ro4350b_4L, 3D_Component_File_Path=C:/Users/tryua/Documents/Ansoft/u_slot_patch_antenna_ro4350b_4L_antenna.a3dcomp, h_copper=1copper_oz_per_ft2, h_dielectric_microstrip=10mil, w_patch=12.020559mm, l_patch=7.2503014mm, y_feed=-0.70991249mm, w_slot=5.0926129mm, l_slot=4.1381164mm, t_slot=0.58305664mm, y_slot=2.3182827mm, r_via=0.3mm, h_prepreg=18mil, h_dielectric_antenna=60mil)
  u_slot_patch_antenna_ro4350b_4L7.placement() in RelativeCS7
  Patch7, Via7 [copper] = part_of(u_slot_patch_antenna_ro4350b_4L7) in RelativeCS7
  u_slot_patch_antenna_ro4350b_4L8 = component(u_slot_patch_antenna_ro4350b_4L, 3D_Component_File_Path=C:/Users/tryua/Documents/Ansoft/u_slot_patch_antenna_ro4350b_4L_antenna.a3dcomp, h_copper=1copper_oz_per_ft2, h_dielectric_microstrip=10mil, w_patch=12.020559mm, l_patch=7.2503014mm, y_feed=-0.70991249mm, w_slot=5.0926129mm, l_slot=4.1381164mm, t_slot=0.58305664mm, y_slot=2.3182827mm, r_via=0.3mm, h_prepreg=18mil, h_dielectric_antenna=60mil)
  u_slot_patch_antenna_ro4350b_4L8.placement() in RelativeCS8
  Patch8, Via8 [copper] = part_of(u_slot_patch_antenna_ro4350b_4L8) in RelativeCS8
  u_slot_patch_antenna_ro4350b_4L9 = component(u_slot_patch_antenna_ro4350b_4L, 3D_Component_File_Path=C:/Users/tryua/Documents/Ansoft/u_slot_patch_antenna_ro4350b_4L_antenna.a3dcomp, h_copper=1copper_oz_per_ft2, h_dielectric_microstrip=10mil, w_patch=12.020559mm, l_patch=7.2503014mm, y_feed=-0.70991249mm, w_slot=5.0926129mm, l_slot=4.1381164mm, t_slot=0.58305664mm, y_slot=2.3182827mm, r_via=0.3mm, h_prepreg=18mil, h_dielectric_antenna=60mil)
  u_slot_patch_antenna_ro4350b_4L9.placement() in RelativeCS9
  Patch9, Via9 [copper] = part_of(u_slot_patch_antenna_ro4350b_4L9) in RelativeCS9
  u_slot_patch_antenna_ro4350b_4L10 = component(u_slot_patch_antenna_ro4350b_4L, 3D_Component_File_Path=C:/Users/tryua/Documents/Ansoft/u_slot_patch_antenna_ro4350b_4L_antenna.a3dcomp, h_copper=1copper_oz_per_ft2, h_dielectric_microstrip=10mil, w_patch=12.020559mm, l_patch=7.2503014mm, y_feed=-0.70991249mm, w_slot=5.0926129mm, l_slot=4.1381164mm, t_slot=0.58305664mm, y_slot=2.3182827mm, r_via=0.3mm, h_prepreg=18mil, h_dielectric_antenna=60mil)
  u_slot_patch_antenna_ro4350b_4L10.placement() in RelativeCS10
  Patch10, Via10 [copper] = part_of(u_slot_patch_antenna_ro4350b_4L10) in RelativeCS10
  u_slot_patch_antenna_ro4350b_4L11 = component(u_slot_patch_antenna_ro4350b_4L, 3D_Component_File_Path=C:/Users/tryua/Documents/Ansoft/u_slot_patch_antenna_ro4350b_4L_antenna.a3dcomp, h_copper=1copper_oz_per_ft2, h_dielectric_microstrip=10mil, w_patch=12.020559mm, l_patch=7.2503014mm, y_feed=-0.70991249mm, w_slot=5.0926129mm, l_slot=4.1381164mm, t_slot=0.58305664mm, y_slot=2.3182827mm, r_via=0.3mm, h_prepreg=18mil, h_dielectric_antenna=60mil)
  u_slot_patch_antenna_ro4350b_4L11.placement() in RelativeCS11
  Patch11, Via11 [copper] = part_of(u_slot_patch_antenna_ro4350b_4L11) in RelativeCS11
  u_slot_patch_antenna_ro4350b_4L12 = component(u_slot_patch_antenna_ro4350b_4L, 3D_Component_File_Path=C:/Users/tryua/Documents/Ansoft/u_slot_patch_antenna_ro4350b_4L_antenna.a3dcomp, h_copper=1copper_oz_per_ft2, h_dielectric_microstrip=10mil, w_patch=12.020559mm, l_patch=7.2503014mm, y_feed=-0.70991249mm, w_slot=5.0926129mm, l_slot=4.1381164mm, t_slot=0.58305664mm, y_slot=2.3182827mm, r_via=0.3mm, h_prepreg=18mil, h_dielectric_antenna=60mil)
  u_slot_patch_antenna_ro4350b_4L12.placement() in RelativeCS12
  Patch12, Via12 [copper] = part_of(u_slot_patch_antenna_ro4350b_4L12) in RelativeCS12
  u_slot_patch_antenna_ro4350b_4L13 = component(u_slot_patch_antenna_ro4350b_4L, 3D_Component_File_Path=C:/Users/tryua/Documents/Ansoft/u_slot_patch_antenna_ro4350b_4L_antenna.a3dcomp, h_copper=1copper_oz_per_ft2, h_dielectric_microstrip=10mil, w_patch=12.020559mm, l_patch=7.2503014mm, y_feed=-0.70991249mm, w_slot=5.0926129mm, l_slot=4.1381164mm, t_slot=0.58305664mm, y_slot=2.3182827mm, r_via=0.3mm, h_prepreg=18mil, h_dielectric_antenna=60mil)
  u_slot_patch_antenna_ro4350b_4L13.placement() in RelativeCS13
  Patch13, Via13 [copper] = part_of(u_slot_patch_antenna_ro4350b_4L13) in RelativeCS13
  u_slot_patch_antenna_ro4350b_4L14 = component(u_slot_patch_antenna_ro4350b_4L, 3D_Component_File_Path=C:/Users/tryua/Documents/Ansoft/u_slot_patch_antenna_ro4350b_4L_antenna.a3dcomp, h_copper=1copper_oz_per_ft2, h_dielectric_microstrip=10mil, w_patch=12.020559mm, l_patch=7.2503014mm, y_feed=-0.70991249mm, w_slot=5.0926129mm, l_slot=4.1381164mm, t_slot=0.58305664mm, y_slot=2.3182827mm, r_via=0.3mm, h_prepreg=18mil, h_dielectric_antenna=60mil)
  u_slot_patch_antenna_ro4350b_4L14.placement() in RelativeCS14
  Patch14, Via14 [copper] = part_of(u_slot_patch_antenna_ro4350b_4L14) in RelativeCS14
  u_slot_patch_antenna_ro4350b_4L15 = component(u_slot_patch_antenna_ro4350b_4L, 3D_Component_File_Path=C:/Users/tryua/Documents/Ansoft/u_slot_patch_antenna_ro4350b_4L_antenna.a3dcomp, h_copper=1copper_oz_per_ft2, h_dielectric_microstrip=10mil, w_patch=12.020559mm, l_patch=7.2503014mm, y_feed=-0.70991249mm, w_slot=5.0926129mm, l_slot=4.1381164mm, t_slot=0.58305664mm, y_slot=2.3182827mm, r_via=0.3mm, h_prepreg=18mil, h_dielectric_antenna=60mil)
  u_slot_patch_antenna_ro4350b_4L15.placement() in RelativeCS15
  Patch15, Via15 [copper] = part_of(u_slot_patch_antenna_ro4350b_4L15) in RelativeCS15
  u_slot_patch_antenna_ro4350b_4L16 = component(u_slot_patch_antenna_ro4350b_4L, 3D_Component_File_Path=C:/Users/tryua/Documents/Ansoft/u_slot_patch_antenna_ro4350b_4L_antenna.a3dcomp, h_copper=1copper_oz_per_ft2, h_dielectric_microstrip=10mil, w_patch=12.020559mm, l_patch=7.2503014mm, y_feed=-0.70991249mm, w_slot=5.0926129mm, l_slot=4.1381164mm, t_slot=0.58305664mm, y_slot=2.3182827mm, r_via=0.3mm, h_prepreg=18mil, h_dielectric_antenna=60mil)
  u_slot_patch_antenna_ro4350b_4L16.placement() in RelativeCS16
  Patch16, Via16 [copper] = part_of(u_slot_patch_antenna_ro4350b_4L16) in RelativeCS16
boundaries and excitations:
  Open1: Radiation Objects=RadiatingSurface
setups:
  Setup1: HfssDriven Frequency=9GHz MaxDeltaE=0.1 MaximumPasses=6 MinimumPasses=1 MinimumConvergedPasses=1 PercentRefinement=30 BasisOrder=1 DrivenSolverType="Direct Solver"
    sweep Sweep: 8GHz to 10GHz, 401 points; Type=Interpolating SaveFields SaveRadFields InterpTolerance=0.5 InterpMaxSolns=250 InterpUsePortImped=false PassivityErrorTolerance=0.0001
radiation setups:
  3D: Infinite Sphere Theta=0deg..180deg step 2deg Phi=-180deg..180deg step 2deg
  Elevation: Infinite Sphere Theta=-180deg..180deg step 1deg Phi=0deg..90deg step 90deg
  Azimuth: Infinite Sphere Theta=90deg..90deg step 0deg Phi=-180deg..180deg step 1deg
reports:
  S Parameter Plot 1: dB(S(1,1)), dB(S(2,2)), dB(S(3,3)), dB(S(4,4)), dB(S(5,5)), dB(S(6,6)), dB(S(7,7)), dB(S(8,8)) vs Freq on Setup1 : Sweep; markers MY1 at y=-10
  Realized Gain Plot 1: dB(RealizedGainTotal) vs Theta on Setup1 : LastAdaptive, 3D [Phi=-180deg,-90deg Freq=9GHz]
  Realized Gain Plot 2: dB(RealizedGainTotal) vs Phi, Theta on Setup1 : LastAdaptive, 3D [Freq=9GHz]
  Antenna Params Plot 1: dB(PeakRealizedGain) vs Freq on Setup1 : Sweep
  S Parameter Plot1: dB(S(2,1)), dB(S(5,1)), dB(S(3,2)), dB(S(6,2)), dB(S(4,3)), dB(S(7,3)), dB(S(8,4)) vs Freq on Setup1 : Sweep
