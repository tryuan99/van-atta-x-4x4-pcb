# Ansys Electronics Desktop project, version 2021.2
materials:
  air: permittivity=1.0006 permeability=1.0000004
  vacuum: permittivity=1
  pec: conductivity=1e+30
  copper: conductivity=58004640
  FR4_epoxy: permittivity=4.4 dielectric_loss_tangent=0.02
  Rogers RO4350B: permittivity=3.48 dielectric_loss_tangent=0.004
  Rogers RO4450F Prepreg: permittivity=3.52 dielectric_loss_tangent=0.004
  solder: conductivity=7000000

design HFSSDesign1 (HFSS, DrivenTerminal, model units mm)
options: Allow_Material_Override Calculate_Lossy_Dielectrics
geometry:
  Core_1, Core_2 [Rogers RO4350B] = imported_body()
  Prepreg_1 [Rogers RO4450F Prepreg] = imported_body()
  Signal_Layer_1, Signal_Layer_1_L1, Signal_Layer_1_L10..Signal_Layer_1_L19, Signal_Layer_1_L2..Signal_Layer_1_L9 [copper] = imported_body()
  Signal_Layer_1_t_fill [FR4_epoxy] = imported_body()
  Signal_Layer_2_t_fill [Rogers RO4350B] = imported_body()
  Signal_Layer_3 [copper] = imported_body()
  Signal_Layer_3_t_fill [Rogers RO4350B] = imported_body()
  Signal_Layer_4, Signal_Layer_4_L1, Signal_Layer_4_L10, Signal_Layer_4_L11, Signal_Layer_4_L2..Signal_Layer_4_L9 [copper] = imported_body()
  Signal_Layer_4_t_fill [FR4_epoxy] = imported_body()
  Via1, Via10..Via19, Via2, Via20, Via3..Via9 [copper] = imported_body()
  airbox [air] = imported_body()
boundaries and excitations:
  airbox_RAD: Radiation Objects=airbox
mesh:
  initial mesh: GlobalSurfApproximation{SurfDevChoice=0 NormalDevChoice=1 AspectRatioChoice=1 SetFacePreservationLevel=0} MeshMethod=AnsoftClassic
setups:
  Setup1: HfssDriven Frequency=9GHz MaxDeltaS=0.02 MaximumPasses=10 MinimumPasses=1 MinimumConvergedPasses=1 PercentRefinement=30 BasisOrder=-1 SolveInsideMetalBasis=-1 Target=0.666667 PortAccuracy=2 SolverType="Auto Solver" SaveAnyFields=false UsingNumSolveSteps=0 ConstantDelta=0s NumberSolveSteps=1
    sweep Sweep1: 6GHz to 12GHz step 0.01GHz; Type=Interpolating InterpTolerance=0.5 InterpMaxSolns=250 PassivityErrorTolerance=0.0001
