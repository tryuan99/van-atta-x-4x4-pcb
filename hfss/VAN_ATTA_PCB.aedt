# Ansys Electronics Desktop project, version 2025.2
materials:
  air: permittivity=1.0006 permeability=1.0000004
  vacuum: permittivity=1
  pec: conductivity=1e+30
  copper: conductivity=58004640
  FR4_epoxy: permittivity=4.4 dielectric_loss_tangent=0.02
  Rogers RO4350B: permittivity=3.48 dielectric_loss_tangent=0.004
  Rogers RO4450F Prepreg: permittivity=3.52 dielectric_loss_tangent=0.004
  solder: conductivity=7000000

design HFSSDesign1 (HFSS, HFSS Modal Network, model units mm)
options: Allow_Material_Override Calculate_Lossy_Dielectrics Save_Adaptive_support_files
geometry:
  Core_1, Core_2 [Rogers RO4350B] = imported_body()
  Prepreg_1 [Rogers RO4450F Prepreg] = imported_body()
  Signal_Layer_1, Signal_Layer_1_L1, Signal_Layer_1_L10..Signal_Layer_1_L19, Signal_Layer_1_L2..Signal_Layer_1_L9 [copper] = imported_body()
  Signal_Layer_2_t_fill [Rogers RO4350B] = imported_body()
  Signal_Layer_3 [copper] = imported_body()
  Signal_Layer_3_t_fill [Rogers RO4350B] = imported_body()
  Signal_Layer_4, Signal_Layer_4_L1, Signal_Layer_4_L10, Signal_Layer_4_L11, Signal_Layer_4_L2..Signal_Layer_4_L9, Via1, Via10..Via19, Via2, Via20, Via3..Via9 [copper] = imported_body()
  RadiatingSurface [air] = region(absolute_offset=11.111111mm on all sides)
boundaries and excitations:
  Open1: Radiation Objects=RadiatingSurface
  IncPWave1: Plane Incident Wave PhiStart=90deg PhiStop=90deg PhiPoints=1 ThetaStart=0deg ThetaStop=90deg ThetaPoints=7 EoPhi=1 EoTheta=0 OriginX=0mm OriginY=0mm OriginZ=0mm IsPropagating
mesh:
  initial mesh: MeshMethod=AnsoftClassic
setups:
  Setup1: HfssDriven Frequency=9GHz MaxDeltaE=0.1 MaximumPasses=10 MinimumPasses=1 MinimumConvergedPasses=1 PercentRefinement=30 BasisOrder=-1 Target=0.666667 DrivenSolverType="Direct Solver" SaveRadFieldsOnly
source amplitudes:
  IncPWave1:1: 1 0deg
radiation setups:
  3D: Infinite Sphere Theta=0deg..180deg step 2deg Phi=-180deg..180deg step 2deg
  Elevation: Infinite Sphere Theta=-180deg..180deg step 1deg Phi=0deg..90deg step 90deg
  Azimuth: Infinite Sphere Theta=90deg..90deg step 0deg Phi=-180deg..180deg step 1deg
reports:
  Monostatic RCS Plot1: dB(MonostaticRCSTotal) vs IWaveTheta on Setup1 : LastAdaptive [IWavePhi=all Freq=9GHz]
  rE Plot1: dB(rETotal) vs Theta on Setup1 : LastAdaptive, 3D [Phi=-90deg Freq=9GHz IWavePhi=all IWaveTheta=all]
  rE Plot2: dB(rETotal) vs Phi, Theta on Setup1 : LastAdaptive, 3D [Freq=9GHz IWavePhi=90deg IWaveTheta=0deg]
